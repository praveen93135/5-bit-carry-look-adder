praveen_2024102019
.include TSMC_180nm.txt
.param SUPPLY=1.8
.option scale=0.09u
.global gnd vdd

VDD   vdd  gnd  {SUPPLY}
VA A 0 PULSE(0 1.8 0n 1n 1n 10n 20n)

VB B 0 PULSE(0 1.8 0n 1n 1n 20n 40n)

VC C 0 PULSE(0 1.8 0n 1n 1n 40n 80n)

M1000 GND C a_3_n30# Gnd CMOSN w=10 l=2
+  ad=50 pd=30 as=40 ps=28
M1001 output A VDD w_n20_n14# CMOSP w=11 l=2
+  ad=121 pd=66 as=121 ps=66
M1002 a_n3_n30# A output Gnd CMOSN w=10 l=2
+  ad=40 pd=28 as=50 ps=30
M1003 VDD B output w_n20_n14# CMOSP w=11 l=2
+  ad=0 pd=0 as=0 ps=0
M1004 a_3_n30# B a_n3_n30# Gnd CMOSN w=10 l=2
+  ad=0 pd=0 as=0 ps=0
M1005 output C VDD w_n20_n14# CMOSP w=11 l=2
+  ad=0 pd=0 as=0 ps=0
C0 A output 0.11fF
C1 VDD C 0.12fF
C2 w_n20_n14# VDD 0.07fF
C3 output C 0.06fF
C4 w_n20_n14# output 0.04fF
C5 w_n20_n14# A 0.08fF
C6 VDD B 0.12fF
C7 B output 0.06fF
C8 w_n20_n14# C 0.08fF
C9 B A 0.18fF
C10 B C 0.21fF
C11 w_n20_n14# B 0.09fF
C12 VDD A 0.12fF
C13 GND Gnd 0.01fF
C14 output Gnd 0.06fF
C15 VDD Gnd 0.05fF
C16 C Gnd 0.14fF
C17 B Gnd 0.14fF
C18 A Gnd 0.17fF
C19 w_n20_n14# Gnd 0.92fF

.tran 1n 160n

.control
    run
    plot v(a) v(b)+2 v(c)+4 v(output)+6
.endc
